* Sine chain, ideal behavioural parts (no vendor models). Mirrors signal_gen sheet values.
.param code=16383
* AD9833 stand-in: 60 Hz, 0.313 V pk about ~0.35 V mid-level
Vdds dds 0 SIN(0.35 0.313 60)
C44 dds np 1u
R32 np 0 100k
* OPA1655 stand-in: rail-limited high-gain VCVS with 1 MHz GBW pole; gain 1 + 50.6k/3.3k
Bop1 o1i 0 V=max(min(1e6*(V(np)-V(inv1)),14),-14)
Rp1 o1i o1 1k
Cp1 o1 0 0.16u
R45 o1 inv1 50.6k
C84 o1 inv1 1n
R46 inv1 0 3.3k
R50 o1 vref 220
* MMBZ9V1ALT1G between its cathodes: two 9.1 V zeners back to back
Dz1 vref zmid DZ
Dz2 0 zmid DZ
.model DZ D(Is=1e-12 N=1 BV=9.1 IBV=5m Rs=5)
* AD5453 behavioural: 9k ladder from VREF, IOUT1 = VREF x code / 16384 / 9k, 9k RFB
Rladder vref 0 9k
Biout 0 iout I=V(vref)*{code}/16384/9k
Rfb iout oo 9k
C201 iout oo 2p
Riout iout 0 1G
* OPA188 stand-in: inverting output stage, + input grounded
Bop2 o2i 0 V=max(min(1e6*(0-V(iout)),14),-14)
Rp2 o2i oo 1k
Cp2 oo 0 0.16u
R51 oo c2a 100
C2 c2a sig 10u
R33 sig 0 100k
.control
foreach c 0 4096 8192 12288 16383
  alterparam code = $c
  reset
  tran 20u 2 0 20u
  meas tran vrefpk MAX v(vref) from=1.9 to=2
  meas tran sigpk MAX v(sig) from=1.9 to=2
  meas tran sigmin MIN v(sig) from=1.9 to=2
end
* Fault case: input well above normal. VREF must stay inside the +/-12 V limit.
alterparam code = 16383
reset
alter @Vdds[sin] = [ 0.35 2 60 ]
tran 20u 2 0 20u
meas tran vrefmax MAX v(vref) from=1.9 to=2
meas tran vrefmin MIN v(vref) from=1.9 to=2
meas tran zo1 MAX v(o1) from=1.9 to=2
.endc
.end
